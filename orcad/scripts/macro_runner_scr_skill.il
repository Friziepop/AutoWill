printf("starting running allegro symbol creator skill (macro)")
axlShell("replay C:\\Users\\lavi\\Desktop\\project_wil\\AutoWill\\orcad\\scripts\\setupGrid.scr")
